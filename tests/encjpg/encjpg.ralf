field    qmtx {
    bits        32;
    reset       'h0;
}

field       addr {
    bits    32;
    reset   'h0;
    constraint  c_bufy {
        value & 16'hFFFF == 0;
    }
}

register CFG {
    bytes       4;
    field   inMode {
        bits    1;
        reset   1'b1;
        constraint  c_mode {};
    }
    field   lbufDep {
        bits    2;
        reset   2'h2;
        constraint  c_lbuf {
            value != 0;
        }
    }
    field   srcSel {
        bits    5;
        reset   5'b0;
        constraint c_sel {};
    }
    field   offsetX {
        bits    8;
        reset   8'b0;
    }
    field   offsetY {
        bits    8;
        reset   8'b0;
    }
    field   reserved {
        bits    8; 
    }
}

register SIZE {
    bytes       4;
    field   width {
        bits    12;
        reset   128;
        constraint  c_width {
            value & 1'b1 == 0;
        }
    }
    field   reserved {
        bits    4;
    }
    field   height {
        bits    12;
        reset   96;
        constraint  c_height {}
    }
    field   reserved {
        bits    4;
    }
}

register MBSIZE {
    bytes       4;
    field   mbWidth {
        bits    8;
        reset   8;
    }
    field   mbHeight {
        bits    8;
        reset   6;
    }
    field   mbTotal {
        bits    16;
        reset   48;
    }
}

register STRIDE {
    bytes       4;
    field   stride {
        bits    8;
        reset   8;
    }
    field   reserved {
        bits    24;
    }
}



register QMTX0 {
    bytes       4;
    field       qmtx;
}

register QMTX1 {
    bytes       4;
    field       qmtx;
}

register QMTX2 {
    bytes       4;
    field       qmtx;
}

register QMTX3 {
    bytes       4;
    field       qmtx;
}

register QMTX4 {
    bytes       4;
    field       qmtx;
}

register QMTX5 {
    bytes       4;
    field       qmtx;
}

register QMTX6 {
    bytes       4;
    field       qmtx;
}

register QMTX7 {
    bytes       4;
    field       qmtx;
}

register QMTXW {
    bytes       4;
    field       qmtxWe {
        bits    1;
        reset   'h0;
    }
    field       qmtxWa {
        bits    3;
        reset   'h0;
    }
    field       reserved {
        bits    28;
    }
}



register BUFY {
    bytes       4;
    field       addr=addrY;   
}

register BUFUV {
    bytes       4;
    field       addr=addrUV;
}

register BUFO {
    bytes       4;
    field       addr=addrO;
}

register START {
    bytes       4;
    field       en {
        bits    1;
        reset   'h0;
    }
    field       reserved {
        bits    31;
    }
}

register CTRL {
    bytes       4;
    field       commit {
        bits    1;
        reset   'h0;
    }
    field       reserved {
        bits    31;
    }
}

register INTEB {
    bytes       4;
    field       enoughByte {
        bits    4;
        reset   'h0;
    }
}

register INTEN {
    bytes       4;
    field       eb {
        bits    1;
        reset   'h0;
    }
    field       eof {
        bits    1;
        reset   'h1;
    }
    field       over {
        bits    1;
        reset   'h0;
    }
}

register INT {
    bytes       4;
    field       eof {
        bits    1;
        reset   'h0;
    }
    field       enough {
        bits    1;
        reset   'h0
    }
    field       over {
        bits    1;
        reset   'h0;
    }
}

register SLEN {
    bytes       4;
    field       slen {
        bits    32;
        reset   'h0;
    }
}

block encjpg_reg {
    bytes       92;
    register    CFG;
    register    SIZE;
    register    MBSIZE;
    register    STRIDE;
    register    QMTX0;
    register    QMTX1;
    register    QMTX2;
    register    QMTX3;
    register    QMTX4;
    register    QMTX5;
    register    QMTX6;
    register    QMTX7;
    register    QMTXW;
    register    BUFY;
    register    BUFUV;
    register    BUFO;
    register    START;
    register    CTRL;
    register    INTEB;
    register    INTEN;
    register    INT;
    register    SLEN;
}
